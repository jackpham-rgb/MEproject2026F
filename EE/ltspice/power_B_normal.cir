* Concept A power design B (12 V adapter + XL4015 buck 5.8 V), case: normal
* Generated by EE/ee_calcs.py (servo currents = EST model, see EE/README.md)
* --- design B: 12 V 2 A wall adapter, cord, jack ---
VADP adp 0 12.0
RADP adp n1 0.15
RCORD n1 n2 0.1
LCORD n2 n3 1.5e-06
RJACK n3 vin 0.01
* --- XL4015 buck, averaged: 5.8 V out, 30 mOhm output resistance, input current = Pout / (eff x Vin) ---
CIN vin cinn 220u IC=12
RCIN cinn 0 0.1
BBUCK bo 0 V=5.8
VSENSE bo bo2 0
RBOUT bo2 bk 0.03
BBIN vin 0 I=5.8*I(VSENSE)/(0.9*max(V(vin),1))
VRAIL bk bkr 0
RRAIL bkr rail 0.05
CRAIL rail nc 0.001 IC=5.8
RESR nc 0 0.08
* --- Uno on VIN: M7 diode (~1.0 V) + NCP1117 5 V regulator (dropout ~1.1 V) ---
RVIN vin vinu 0.05
IUNO vinu 0 0.0586
BREG uno5v 0 V=min(5.0,V(vinu)-2.1)
RREGL uno5v 0 1meg
RL_turn bk v_turn 0.08
I_turn v_turn 0 PWL file=pwl/i_turn.txt
IPU_turn v_turn 0 PULSE(0 0.0 0.05 1m 1m 0.27999999999999997 100)
RL_lift rail v_lift 0.13
I_lift v_lift 0 PWL file=pwl/i_lift.txt
IPU_lift v_lift 0 PULSE(0 0.0 0.35 1m 1m 0.27999999999999997 100)
RL_wrist rail v_wrist 0.13
I_wrist v_wrist 0 PWL file=pwl/i_wrist.txt
IPU_wrist v_wrist 0 PULSE(0 0.0 0.65 1m 1m 0.27999999999999997 100)
RL_grip rail v_grip 0.13
I_grip v_grip 0 PWL file=pwl/i_grip.txt
IPU_grip v_grip 0 PULSE(0 0.0 0.9500000000000001 1m 1m 0.27999999999999997 100)
ISTALL v_turn 0 PULSE(0 0.0 4.8 1m 1m 0.5 100)
.tran 1m 16.520 0 2m uic
.end
