* Concept A final power: Uno on a 9 V battery (fresh), servos on 12 V adapter -> XL4015 5.8 V; 1000 uF on the rail: yes; case powerup
* Generated by backend/ee/power_final.py
* --- Uno: 9 V battery -> barrel jack -> M7 diode (~1.0 V) -> NCP1117 5 V (dropout ~1.1 V) ---
VBAT bat 0 9.3
RBAT bat bj 1.5
IUNO bj 0 0.0586
BREG uno5v 0 V=min(5.0,max(V(bj)-2.1,0))
RREGL uno5v 0 1meg
* --- servos: 12 V 2 A adapter -> XL4015 (averaged), module input 220 uF, output 220 uF ---
VADP adp 0 12.0
RADP adp vin 0.25
CIN vin cinn 220u IC=12
RCIN cinn 0 0.1
BBUCK bo 0 V=5.8
VSENSE bo bo2 0
RBOUT bo2 bk 0.03
BBIN vin 0 I=5.8*I(VSENSE)/(0.9*max(V(vin),1))
COUT bk coutn 220u IC=5.8
RCOUT coutn 0 0.15
VRAIL bk bkr 0
RRAIL bkr rail 0.05
CRAIL rail nc 1000u IC=5.8
RESR nc 0 0.08
RL_turn bk v_turn 0.08
I_turn v_turn 0 PWL file=pwl/i_turn.txt
IPU_turn v_turn 0 PULSE(0 2.5 0.05 1m 1m 0.28 100)
RL_lift rail v_lift 0.13
I_lift v_lift 0 PWL file=pwl/i_lift.txt
IPU_lift v_lift 0 PULSE(0 0.7 0.35 1m 1m 0.28 100)
RL_wrist rail v_wrist 0.13
I_wrist v_wrist 0 PWL file=pwl/i_wrist.txt
IPU_wrist v_wrist 0 PULSE(0 0.7 0.65 1m 1m 0.28 100)
RL_grip rail v_grip 0.13
I_grip v_grip 0 PWL file=pwl/i_grip.txt
IPU_grip v_grip 0 PULSE(0 0.65 0.9500000000000001 1m 1m 0.28 100)
ISTALL v_turn 0 PULSE(0 0.0 3.0 1m 1m 0.5 100)
.tran 1m 16.510 0 2m uic
.end
