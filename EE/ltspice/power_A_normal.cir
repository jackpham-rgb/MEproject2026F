* Concept A power design A (5 V adapter direct), case: normal
* Generated by backend/ee/ee_calcs.py (servo currents = EST model, see EE/README.md)
* --- design A: 5 V 4 A wall adapter, cord, jack, rail; Uno on its 5V pin ---
VADP adp 0 5.0
RADP adp n1 0.06
RCORD n1 n2 0.1
LCORD n2 n3 1.5e-06
RJACK n3 jack 0.01
VRAIL jack jr 0
RRAIL jr rail 0.05
CRAIL rail nc 0.001 IC=5.0
RESR nc 0 0.08
RUNO rail uno5v 0.05
IUNO uno5v 0 0.0586
RL_turn jack v_turn 0.08
I_turn v_turn 0 PWL file=pwl/i_turn.txt
IPU_turn v_turn 0 PULSE(0 0.0 0.05 1m 1m 0.27999999999999997 100)
RL_lift rail v_lift 0.13
I_lift v_lift 0 PWL file=pwl/i_lift.txt
IPU_lift v_lift 0 PULSE(0 0.0 0.35 1m 1m 0.27999999999999997 100)
RL_wrist rail v_wrist 0.13
I_wrist v_wrist 0 PWL file=pwl/i_wrist.txt
IPU_wrist v_wrist 0 PULSE(0 0.0 0.65 1m 1m 0.27999999999999997 100)
RL_grip rail v_grip 0.13
I_grip v_grip 0 PWL file=pwl/i_grip.txt
IPU_grip v_grip 0 PULSE(0 0.0 0.9500000000000001 1m 1m 0.27999999999999997 100)
ISTALL v_turn 0 PULSE(0 0.0 4.8 1m 1m 0.5 100)
.tran 1m 16.520 0 2m uic
.end
