* Concept A (power design B): servo PWM signals and loads in firmware order (stall test = 0)
* Generated by EE/ee_calcs.py. LTspice: File > Open (Netlists), then Run; the PWL files are in pwl/.
* EE/ee_calcs.py runs this same circuit in ngspice with the PWL data written inline.
* --- design B: 12 V 2 A wall adapter, cord, jack ---
VADP adp 0 12.0
RADP adp n1 0.15
RCORD n1 n2 0.1
LCORD n2 n3 1.5e-06
RJACK n3 vin 0.01
* --- XL4015 buck, averaged: 5.8 V out, 30 mOhm output resistance, input current = Pout / (eff x Vin) ---
CIN vin cinn 220u IC=12
RCIN cinn 0 0.1
BBUCK bo 0 V=5.8
VSENSE bo bo2 0
RBOUT bo2 bk 0.03
BBIN vin 0 I=5.8*I(VSENSE)/(0.9*max(V(vin),1))
VRAIL bk bkr 0
RRAIL bkr rail 0.05
CRAIL rail nc 0.001 IC=5.8
RESR nc 0 0.08
* --- Uno on VIN: M7 diode (~1.0 V) + NCP1117 5 V regulator (dropout ~1.1 V) ---
RVIN vin vinu 0.05
IUNO vinu 0 0.0450
BREG uno5v 0 V=min(5.0,V(vinu)-2.1)
RREGL uno5v 0 1meg
* --- servos: lead resistance + supply current (EST model) ---
RL_turn bk v_turn 0.08
I_turn v_turn 0 PWL file=pwl/i_turn.txt
RL_lift rail v_lift 0.13
I_lift v_lift 0 PWL file=pwl/i_lift.txt
RL_wrist rail v_wrist 0.13
I_wrist v_wrist 0 PWL file=pwl/i_wrist.txt
RL_grip rail v_grip 0.13
I_grip v_grip 0 PWL file=pwl/i_grip.txt
ISTALL v_turn 0 PULSE(0 0.0 4.8 1m 1m 0.5 100)
* --- servo signal pins (Timer1 pulses, back to back: D9, D10, D6, D5); pin ~25 ohm, servo input ~10k ---
VSIG_D9 pin_d9_src 0 PWL file=pwl/sig_D9.txt
RPIN_D9 pin_d9_src d9 25
RIN_D9 d9 0 10k
VSIG_D10 pin_d10_src 0 PWL file=pwl/sig_D10.txt
RPIN_D10 pin_d10_src d10 25
RIN_D10 d10 0 10k
VSIG_D6 pin_d6_src 0 PWL file=pwl/sig_D6.txt
RPIN_D6 pin_d6_src d6 25
RIN_D6 d6 0 10k
VSIG_D5 pin_d5_src 0 PWL file=pwl/sig_D5.txt
RPIN_D5 pin_d5_src d5 25
RIN_D5 d5 0 10k
* --- status LED on D13 ---
VLED_D13 d13src 0 PWL file=pwl/led_D13.txt
RPIN13 d13src d13 25
R13 d13 led_a 220
DLED led_a 0 YLED
.model YLED D(IS=4e-19 N=2 RS=2)
* --- START button on D4: INPUT_PULLUP (~35k) to the Uno 5V, button to GND ---
RPU uno5v d4 35k
SBTN d4 0 btnc 0 SWBTN
VBTN btnc 0 PWL file=pwl/btn_ctrl.txt
.model SWBTN SW(Ron=0.1 Roff=1e9 Vt=0.5 Vh=0.1)
.tran 1m 16.520 0 2m uic
.end
